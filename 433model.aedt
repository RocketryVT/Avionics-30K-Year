# Ansys Electronics Desktop project, version 2025.2
materials:
  vacuum: permittivity=1
  PVC plastic: permittivity=2.7 dielectric_loss_tangent=0.007
  aluminum: permeability=1.000021 conductivity=38000000

design HFSSDesign1 (HFSS, HFSS Modal Network, model units mm)
geometry:
  ansys433antenna_Unnamed_1 [PVC plastic] = imported_body(C:\Users\nruzz\Downloads\ansys433antenna.x_t)
  ansys433antenna_Unnamed_2..ansys433antenna_Unnamed_9 [aluminum] = imported_body(C:\Users\nruzz\Downloads\ansys433antenna.x_t)
  Box1 = box(corner=(10mm, 230mm, 0mm), size=(-70mm, 30mm, 6mm))
  Box1.move(25mm, -5mm, -1mm)
  Box1.move(-28.65mm, -2mm, -2mm)
  Box1.move(28.65mm, -2.8421709e-14mm, 156mm)
  Box1.move(41.35mm, 0mm, -156mm)
  Box1.move(-40mm, 0mm, 0mm)
  ansys433antenna_Unnamed_3.subtract(Box1)
  Rectangle1 = rectangle(corner=(0mm, 230mm, 10mm), y_size=20mm, z_size=-20mm)
  Rectangle1.move(0mm, -2mm, 0mm)
  Region [vacuum] = region(absolute_offset=200mm on all sides)
  ansys433antenna_Unnamed_2_1 = ansys433antenna_Unnamed_2.copy()
  ansys433antenna_Unnamed_3_1 = ansys433antenna_Unnamed_3.copy()
  ansys433antenna_Unnamed_4_1 = ansys433antenna_Unnamed_4.copy()
  ansys433antenna_Unnamed_5_1 = ansys433antenna_Unnamed_5.copy()
  ansys433antenna_Unnamed_6_1 = ansys433antenna_Unnamed_6.copy()
  ansys433antenna_Unnamed_7_1 = ansys433antenna_Unnamed_7.copy()
  ansys433antenna_Unnamed_8_1 = ansys433antenna_Unnamed_8.copy()
  ansys433antenna_Unnamed_9_1 = ansys433antenna_Unnamed_9.copy()
  ansys433antenna_Unnamed_1.subtract(ansys433antenna_Unnamed_2_1, ansys433antenna_Unnamed_3_1, ansys433antenna_Unnamed_4_1, ansys433antenna_Unnamed_5_1, ansys433antenna_Unnamed_6_1, ansys433antenna_Unnamed_7_1, ansys433antenna_Unnamed_8_1, ansys433antenna_Unnamed_9_1)
  group ansys433antenna = ansys433antenna_Unnamed_1..ansys433antenna_Unnamed_9
boundaries and excitations:
  Rad1: Radiation Objects=Region
  1: Lumped Port Objects=Rectangle1 LumpedPortType=Modal Modes{Mode1{IntLine{(0mm, 238000mm, -4000mm) -> (0mm, 238000mm, 4000mm)} CharImp=Zpi}} Impedance=50ohm
setups:
  Setup1: HfssDriven Frequency=433MHz MaxDeltaS=0.02 MaximumPasses=15 MinimumPasses=1 MinimumConvergedPasses=1 PercentRefinement=30 BasisOrder=1 PortAccuracy=2 DrivenSolverType="Direct Solver"
    sweep Sweep: 216.5MHz to 649.5MHz, 401 points; Type=Interpolating SaveFields InterpTolerance=0.5 InterpMaxSolns=250 InterpUsePortImped=false PassivityErrorTolerance=0.0001
    sweep Sweep1: 400MHz to 470MHz step 5MHz; Type=Discrete SaveFields
source amplitudes:
  1:1: 1W 0deg
radiation setups:
  Infinite Sphere1: Infinite Sphere Theta=0deg..360deg step 2deg Phi=0deg..180deg step 2deg
reports:
  S Parameter Plot1: dB(S(1,1)) vs Freq on Setup1 : Sweep1
  VSWR Plot1: VSWR(1) vs Freq on Setup1 : Sweep1
  Z Parameter Plot1: im(Z(1,1)) vs Freq on Setup1 : Sweep1
  Z Parameter Plot2: re(Z(1,1)), im(Z(1,1)) vs Freq on Setup1 : Sweep1
  Active Z Parameter Plot1: re(ActiveZ(1:1)) vs Freq on Setup1 : Sweep1
  Gamma Plot1: im(Gamma(1)) vs Freq on Setup1 : Sweep1
  Realized Gain Plot1: dB(RealizedGainTotal) vs Phi, Theta on Setup1 : LastAdaptive, Infinite Sphere1 [Freq=0.433GHz]
  Directivity Plot1: dB(DirTotal) vs Phi, Theta on Setup1 : LastAdaptive, Infinite Sphere1 [Freq=0.433GHz]
